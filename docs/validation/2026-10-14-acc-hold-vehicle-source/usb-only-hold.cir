ACC diode OR vehicle-powered HOLD nominal 6V 010
Vacc acc 0 0
Vhold hold 0 2.4
Vqual raw5 0 0
Racc1 acc am 100k
Racc2 am ac 100k
Dz 0 ac DZ
Dacc ac en DS
Ren en 0 100k
Cen en 0 10n
Rpg raw5 pg 4.7k
Mp pd pg raw5 raw5 PM
Dhold pd en DS
Rh hold hg 10k
Rhp hg 0 100k
Mn pg hg 0 0 NM
.model NM NMOS(VTO=1.5 KP=0.1 RD=3 RS=3)
.model PM PMOS(VTO=-2 KP=0.01 RD=10 RS=10)
.model DZ D(IS=1e-14 BV=4.7 IBV=10u)
.model DS D(IS=1e-14 N=1)
Bpleak raw5 pd I=0*min(1,max(v(raw5,pd)/0.1,0))
Bnleak pg 0 I=0*min(1,max(v(pg)/0.1,0))
Benleak en 0 I=200n*min(1,max(v(en)/0.1,0))
.op
.end
